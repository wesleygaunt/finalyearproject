simulator( 'hspiceD )
design(	 "/home/matdou01/simulation/SimpleNN_8D_tb/hspiceD/schematic/netlist/netlist")
resultsDir( "/home/matdou01/simulation/SimpleNN_8D_tb/hspiceD/schematic" )
modelFile(
    '("/projects/randd/ejis/users/matdou01/testproject/nch_t.model" "")
)
;Open files
in = infile("./Test5-8DIn/XData_8D_PosW.in")
DebugOut = outfile("./Test5-8DIn/DebugOut_8D_NoSamp_2V475b_500u_OctMod.out" "w")
YOut = outfile("./Test5-8DIn/YData_8D_NoSamp_2V475b_500u_OctMod.out" "w")
;Read file and extract 3 4bit inputs, X0, X1 and X2
STATUS = fscanf(in "%f %f %f %f %f %f %f %f %f %f %f %f %f %f %f %f %f %f %f %f %f %f %f %f %f %f %f %f %f %f %f %f" X0_b3_temp X0_b2_temp X0_b1_temp X0_b0_temp X1_b3_temp X1_b2_temp X1_b1_temp X1_b0_temp X2_b3_temp X2_b2_temp X2_b1_temp X2_b0_temp X3_b3_temp X3_b2_temp X3_b1_temp X3_b0_temp X4_b3_temp X4_b2_temp X4_b1_temp X4_b0_temp X5_b3_temp X5_b2_temp X5_b1_temp X5_b0_temp X6_b3_temp X6_b2_temp X6_b1_temp X6_b0_temp X7_b3_temp X7_b2_temp X7_b1_temp X7_b0_temp)
x=1; counter for loops
;begin Simulation loop
;Condition can be either STATUS to simulate all data, or x<5 (for example) for testing.
if(STATUS printf("******non-nil******\n") printf("******nil******\n"))
while(STATUS
printf("Read Line: %d \n", x)
analysis('tran ?start "0"  ?stop "500u"  ?step "10n"  )
desVar(	  "CAP" 7p	)
desVar(	  "CAPDIFF" 16p	)
desVar(	  "PERIOD" 500u	)
desVar(	  "TCapDiff" 490u)
desVar(	  "T_OUT" 5u	)
desVar(	  "T_RST" 2u	)
desVar(	  "Tsamp" 1.6u	)
desVar(	  "VB" 2.475	)
desVar(	  "VDD" 4.5	)
desVar(	  "W0_b0" 0	)
desVar(	  "W0_b1" 4.5	)
desVar(	  "W0_b2" 0	)
desVar(	  "W0_b3" 0	)
desVar(	  "W1_b0" 4.5	)
desVar(	  "W1_b1" 0	)
desVar(	  "W1_b2" 0	)
desVar(	  "W2_b0" 0	)
desVar(	  "W2_b1" 0	)
desVar(	  "W2_b2" 0	)
desVar(	  "W3_b0" 0	)
desVar(	  "W3_b1" 4.5	)
desVar(	  "W3_b2" 0	)
desVar(	  "W4_b0" 0	)
desVar(	  "W4_b1" 4.5	)
desVar(	  "W4_b2" 4.5	)
desVar(	  "W5_b0" 0	)
desVar(	  "W5_b1" 4.5	)
desVar(	  "W5_b2" 0	)
desVar(	  "W6_b0" 4.5	)
desVar(	  "W6_b1" 0	)
desVar(	  "W6_b2" 0	)
desVar(	  "W7_b0" 0	)
desVar(	  "W7_b1" 4.5	)
desVar(	  "W7_b2" 0	)
desVar(	  "X2_b3" X2_b3_temp)
desVar(	  "X2_b2" X2_b2_temp)
desVar(	  "X2_b1" X2_b1_temp)
desVar(	  "X2_b0" X2_b0_temp)
desVar(	  "X0_b3" X0_b3_temp)
desVar(	  "X0_b2" X0_b2_temp)
desVar(	  "X0_b1" X0_b1_temp)
desVar(	  "X0_b0" X0_b0_temp)
desVar(	  "X1_b3" X1_b3_temp)
desVar(	  "X1_b2" X1_b2_temp)
desVar(	  "X1_b1" X1_b1_temp)
desVar(	  "X1_b0" X1_b0_temp)
desVar(	  "X3_b0" X3_b0_temp)
desVar(	  "X3_b1" X3_b1_temp)
desVar(	  "X3_b2" X3_b2_temp)
desVar(	  "X3_b3" X3_b3_temp)
desVar(	  "X4_b0" X4_b0_temp)
desVar(	  "X4_b1" X4_b1_temp)
desVar(	  "X4_b2" X4_b2_temp)
desVar(	  "X4_b3" X4_b3_temp)
desVar(	  "X5_b0" X5_b0_temp)
desVar(	  "X5_b1" X5_b1_temp)
desVar(	  "X5_b2" X5_b2_temp)
desVar(	  "X5_b3" X5_b3_temp)
desVar(	  "X6_b0" X6_b0_temp)
desVar(	  "X6_b1" X6_b1_temp)
desVar(	  "X6_b2" X6_b2_temp)
desVar(	  "X6_b3" X6_b3_temp)
desVar(	  "X7_b0" X7_b0_temp)
desVar(	  "X7_b1" X7_b1_temp)
desVar(	  "X7_b2" X7_b2_temp)
desVar(	  "X7_b3" X7_b3_temp)
desVar(	  "sim_time" 500u	)
option(	'TEMPDC  "25.0"
)
;save( 'v "/Vout_class" )
temp( 25.0 )
run()
selectResult( 'tran )
outputs()
;Print output data
;time = 7.5e-06
;To aid debugging, add the inputs, comparator input and output to the debug file.
fprintf(DebugOut "L,%d,X0=%1.1f,%1.1f,%1.1f,%1.1f,X1=%1.1f,%1.1f,%1.1f,%1.1f,X2=%1.1f,%1.1f,%1.1f,%1.1f,X3=%1.1f,%1.1f,%1.1f,%1.1f,X4=%1.1f,%1.1f,%1.1f,%1.1f,X5=%1.1f,%1.1f,%1.1f,%1.1f,X6=%1.1f,%1.1f,%1.1f,%1.1f,X7=%1.1f,%1.1f,%1.1f,%1.1f,\n" x X0_b3_temp X0_b2_temp X0_b1_temp X0_b0_temp X1_b3_temp X1_b2_temp X1_b1_temp X1_b0_temp X2_b3_temp X2_b2_temp X2_b1_temp X2_b0_temp X3_b3_temp X3_b2_temp X3_b1_temp X3_b0_temp X4_b3_temp X4_b2_temp X4_b1_temp X4_b0_temp X5_b3_temp X5_b2_temp X5_b1_temp X5_b0_temp X6_b3_temp X6_b2_temp X6_b1_temp X6_b0_temp X7_b3_temp X7_b2_temp X7_b1_temp X7_b0_temp)
fprintf(DebugOut "Vo+=%1.3e,Vo-=%1.3e" value(VT("/Vout_pos") 4.94e-04) value(VT("/Vout_pos") 4.94e-04))
fprintf(DebugOut "Vob+=%1.3e,Vob-=%1.3e" value(VT("/Vout_pos_buff") 4.94e-04) value(VT("/Vout_pos_buff") 4.94e-04))
fprintf(DebugOut "Vcap_o=%1.3e," value(VT("/I28/Vcap_o") 4.975e-04))
fprintf(DebugOut "Vout=%1.3e\n" value(VT("/Vout_class") 4.975e-04))
fprintf(YOut "%d\n" if((value(VT("/Vout_class") 4.975e-04)>4) 1 0))
;Read next line of input file
STATUS = fscanf(in "%f %f %f %f %f %f %f %f %f %f %f %f %f %f %f %f %f %f %f %f %f %f %f %f %f %f %f %f %f %f %f %f" X0_b3_temp X0_b2_temp X0_b1_temp X0_b0_temp X1_b3_temp X1_b2_temp X1_b1_temp X1_b0_temp X2_b3_temp X2_b2_temp X2_b1_temp X2_b0_temp X3_b3_temp X3_b2_temp X3_b1_temp X3_b0_temp X4_b3_temp X4_b2_temp X4_b1_temp X4_b0_temp X5_b3_temp X5_b2_temp X5_b1_temp X5_b0_temp X6_b3_temp X6_b2_temp X6_b1_temp X6_b0_temp X7_b3_temp X7_b2_temp X7_b1_temp X7_b0_temp)
if(STATUS printf("******non-nil******\n") printf("******nil******\n"))
x=x+1
); end of while loop
close(in)
close(DebugOut)
close(YOut)
